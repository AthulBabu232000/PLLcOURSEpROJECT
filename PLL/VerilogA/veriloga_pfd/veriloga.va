// VerilogA for PLL, PFD, veriloga

`include "constants.vams"
`include "disciplines.vams"

module PFD(up,dn,fref,fdiv);

parameter real vtrans=0.5;
parameter real delay = 0;
parameter real ttime = 1p;
parameter real clk_threshold = 0.5;

input fref;
input fdiv;
output up,dn;

electrical fref,fdiv,up,dn;

real fv_rst, fr_rst, reset, upr,dnr;

analog begin

	@(cross(V(fref) - clk_threshold, +1))
	begin
		upr = 1;
	end

	@(cross(V(fdiv) - clk_threshold, +1))
	begin
		dnr = 1;
	end

	if(dnr == upr) begin
		upr = 0; dnr = 0; end

	V(up) <+ transition(upr,delay,ttime);
	V(dn) <+ transition(dnr,delay,ttime);
end
endmodule
